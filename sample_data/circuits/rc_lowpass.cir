* RC Low-Pass Filter Circuit Netlist
* eSim / NgSpice Simulation Example
V1 in 0 AC 1.0 SIN(0 1.0 1k)
R1 in out 1k
C1 out 0 100n
.tran 1u 5m
.ac dec 10 10 100k
.end
